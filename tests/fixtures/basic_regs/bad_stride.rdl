addrmap bad_stride {
    reg {
        field {
            sw = rw;
            hw = r;
        } value[8] = 0;
    } CTRL[4] @ 0x0 += 0x8;
};
